# Ansys Electronics Desktop project, version 2019.2
materials:
  vacuum: permittivity=1

design HFSSDesign1 (HFSS, DrivenModal, model units mm)
variables:
  a = 22.86mm
  b = 10.16mm
  length = 60mm
geometry:
  Box1 [vacuum] = box(corner=(0mm, 0mm, 0mm), size=(a, b, -length))
boundaries and excitations:
  1: Wave Port Faces=Box1.face(+z) NumModes=1 Modes{Mode1{IntLine{middle of Box1.edge(4 of 12) -> middle of Box1.edge(2 of 12)} CharImp=Zpi}}
  2: Wave Port Faces=Box1.face(-z) NumModes=1 Modes{Mode1{IntLine{middle of Box1.edge(6 of 12) -> middle of Box1.edge(8 of 12)} CharImp=Zpi}}
setups:
  Setup1: HfssDriven Frequency=10GHz MaxDeltaS=0.02 MaximumPasses=6 MinimumPasses=1 MinimumConvergedPasses=1 PercentRefinement=30 BasisOrder=1 PortAccuracy=2
    sweep Sweep: 8GHz to 12GHz step 0.05GHz; Type=Interpolating InterpTolerance=0.5 InterpMaxSolns=250 InterpUsePortImped=false PassivityErrorTolerance=0.0001
source amplitudes:
  1:1: 1W 0deg
  2:1: 0W 0deg
reports:
  S Parameter Plot 1: dB(S(1,1)), dB(S(2,1)), dB(S(1,2)), dB(S(2,2)) vs Freq on Setup1 : Sweep
